** sch_path: /foss/designs/synchronos-chipathon-2026/designs/libs/core_analog/vco/vco.sch
.subckt vco_top VOP1 VOP2 VOP3 VOP4 VON1 VON2 VON3 VON4 AVDD AVSS VBP VBN
*.PININFO VOP[1..4]:O VON[1..4]:O VBP:I VBN:I AVDD:B AVSS:B
x1 VOP1 AVDD VOP4 VON4 VON1 AVSS VBP Id1 delay_stage
x2 VOP2 AVDD VON1 VOP1 VON2 AVSS VBP Id2 delay_stage
x3 VOP3 AVDD VON2 VOP2 VON3 AVSS VBP Id3 delay_stage
x4 VOP4 AVDD VON3 VOP3 VON4 AVSS VBP Id4 delay_stage
M8 Id1 VBN AVSS AVSS nfet_03v3 L=0.5u W=2.82u nf=1 m=32
M1 Id2 VBN AVSS AVSS nfet_03v3 L=0.5u W=2.82u nf=1 m=32
M2 Id3 VBN AVSS AVSS nfet_03v3 L=0.5u W=2.82u nf=1 m=32
M3 Id4 VBN AVSS AVSS nfet_03v3 L=0.5u W=2.82u nf=1 m=32
M4 Id2 Id2 Id2 AVSS nfet_03v3 L=0.5u W=2.82u nf=1 m=2
M5 Id4 Id4 Id4 AVSS nfet_03v3 L=0.5u W=2.82u nf=1 m=2
.ends

* expanding   symbol:  libs/core_analog/delay_stage/delay_stage.sym # of pins=8
** sym_path: /foss/designs/synchronos-chipathon-2026/designs/libs/core_analog/delay_stage/delay_stage.sym
** sch_path: /foss/designs/synchronos-chipathon-2026/designs/libs/core_analog/delay_stage/delay_stage.sch
.subckt delay_stage VOP AVDD VIP VIN VON AVSS VBP Id
*.PININFO VIP:I VIN:I VOP:O VON:O AVDD:B AVSS:B VBP:I Id:I
M5 VON VIP Id AVSS nfet_03v3 L=0.5u W=2.08u nf=1 m=8
M2 VON VON AVDD AVDD pfet_03v3 L=1.5u W=1.1u nf=1 m=8
M6 VOP VIN Id AVSS nfet_03v3 L=0.5u W=2.08u nf=1 m=8
M1 VON VBP AVDD AVDD pfet_03v3 L=1.5u W=1.1u nf=1 m=8
M3 VOP VBP AVDD AVDD pfet_03v3 L=1.5u W=1.1u nf=1 m=8
M4 VOP VOP AVDD AVDD pfet_03v3 L=1.5u W=1.1u nf=1 m=8
.ends
