* Extracted by KLayout with GF180MCU LVS runset on : 01/09/2026 09:40

.SUBCKT charge_pump_top UP UP_B IP VDD S1A S1B S2 S4 S8 DN_B DN VSS
M$1 VDD VDD VDD VDD pfet_03v3 L=1.5U W=17.6U AS=8.008P AD=8.008P PS=40.96U
+ PD=40.96U
M$2 \$35 \$35 VDD VDD pfet_03v3 L=1.5U W=8.8U AS=2.288P AD=2.288P PS=12.96U
+ PD=12.96U
M$4 \$40 \$40 VDD VDD pfet_03v3 L=1.5U W=17.6U AS=4.576P AD=4.576P PS=25.92U
+ PD=25.92U
M$10 IP \$140 VDD VDD pfet_03v3 L=1.5U W=17.6U AS=4.576P AD=4.576P PS=25.92U
+ PD=25.92U
M$12 IP \$141 VDD VDD pfet_03v3 L=1.5U W=8.8U AS=2.288P AD=2.288P PS=12.96U
+ PD=12.96U
M$22 \$25 \$25 VDD VDD pfet_03v3 L=1.5U W=2.2U AS=0.572P AD=0.572P PS=3.24U
+ PD=3.24U
M$32 IP \$139 VDD VDD pfet_03v3 L=1.5U W=2.2U AS=0.572P AD=0.572P PS=3.24U
+ PD=3.24U
M$44 \$32 \$32 VDD VDD pfet_03v3 L=1.5U W=4.4U AS=1.144P AD=1.144P PS=6.48U
+ PD=6.48U
M$46 IP \$238 VDD VDD pfet_03v3 L=1.5U W=4.4U AS=1.144P AD=1.144P PS=6.48U
+ PD=6.48U
M$62 \$64 \$64 VDD VDD pfet_03v3 L=1.5U W=2.2U AS=0.572P AD=0.572P PS=3.24U
+ PD=3.24U
M$64 IP \$271 VDD VDD pfet_03v3 L=1.5U W=2.2U AS=0.572P AD=0.572P PS=3.24U
+ PD=3.24U
M$74 \$325 \$325 VDD VDD pfet_03v3 L=1.5U W=17.6U AS=4.576P AD=4.576P PS=25.92U
+ PD=25.92U
M$78 \$326 \$326 VDD VDD pfet_03v3 L=1.5U W=4.4U AS=1.144P AD=1.144P PS=6.48U
+ PD=6.48U
M$80 \$324 \$324 VDD VDD pfet_03v3 L=1.5U W=2.2U AS=0.572P AD=0.572P PS=3.24U
+ PD=3.24U
M$82 \$271 \$271 VDD VDD pfet_03v3 L=1.5U W=2.2U AS=0.572P AD=0.572P PS=3.24U
+ PD=3.24U
M$84 \$238 \$238 VDD VDD pfet_03v3 L=1.5U W=4.4U AS=1.144P AD=1.144P PS=6.48U
+ PD=6.48U
M$86 \$140 \$140 VDD VDD pfet_03v3 L=1.5U W=17.6U AS=4.576P AD=4.576P PS=25.92U
+ PD=25.92U
M$92 \$323 \$323 VDD VDD pfet_03v3 L=1.5U W=8.8U AS=2.288P AD=2.288P PS=12.96U
+ PD=12.96U
M$102 \$141 \$141 VDD VDD pfet_03v3 L=1.5U W=8.8U AS=2.288P AD=2.288P PS=12.96U
+ PD=12.96U
M$130 \$382 \$382 VDD VDD pfet_03v3 L=1.5U W=2.2U AS=0.572P AD=0.572P PS=3.24U
+ PD=3.24U
M$140 \$139 \$139 VDD VDD pfet_03v3 L=1.5U W=2.2U AS=0.572P AD=0.572P PS=3.24U
+ PD=3.24U
M$145 \$31 UP_B \$32 VSS nfet_03v3 L=0.5U W=4.16U AS=1.8096P AD=1.8096P
+ PS=7.98U PD=7.98U
M$146 IP UP \$31 VSS nfet_03v3 L=0.5U W=4.16U AS=1.0816P AD=1.0816P PS=5.2U
+ PD=5.2U
M$149 \$145 DN_B \$326 VSS nfet_03v3 L=0.5U W=4.16U AS=1.8096P AD=1.8096P
+ PS=7.98U PD=7.98U
M$150 \$238 DN \$145 VSS nfet_03v3 L=0.5U W=4.16U AS=1.0816P AD=1.0816P PS=5.2U
+ PD=5.2U
M$153 \$26 UP_B \$25 VSS nfet_03v3 L=0.5U W=2.08U AS=1.2688P AD=0.5408P
+ PS=5.38U PD=2.6U
M$154 IP UP \$26 VSS nfet_03v3 L=0.5U W=2.08U AS=0.5408P AD=1.2688P PS=2.6U
+ PD=5.38U
M$155 \$30 UP_B \$64 VSS nfet_03v3 L=0.5U W=2.08U AS=1.2688P AD=0.5408P
+ PS=5.38U PD=2.6U
M$156 IP UP \$30 VSS nfet_03v3 L=0.5U W=2.08U AS=0.5408P AD=1.2688P PS=2.6U
+ PD=5.38U
M$157 \$27 DN_B \$324 VSS nfet_03v3 L=0.5U W=2.08U AS=1.2688P AD=0.5408P
+ PS=5.38U PD=2.6U
M$158 \$271 DN \$27 VSS nfet_03v3 L=0.5U W=2.08U AS=0.5408P AD=1.2688P PS=2.6U
+ PD=5.38U
M$159 \$142 DN_B \$382 VSS nfet_03v3 L=0.5U W=2.08U AS=1.2688P AD=0.5408P
+ PS=5.38U PD=2.6U
M$160 \$139 DN \$142 VSS nfet_03v3 L=0.5U W=2.08U AS=0.5408P AD=1.2688P PS=2.6U
+ PD=5.38U
M$161 \$29 UP_B \$40 VSS nfet_03v3 L=0.5U W=16.64U AS=5.0544P AD=5.0544P
+ PS=23.58U PD=23.58U
M$162 IP UP \$29 VSS nfet_03v3 L=0.5U W=16.64U AS=4.3264P AD=4.3264P PS=20.8U
+ PD=20.8U
M$177 \$146 DN_B \$325 VSS nfet_03v3 L=0.5U W=16.64U AS=5.0544P AD=5.0544P
+ PS=23.58U PD=23.58U
M$178 \$140 DN \$146 VSS nfet_03v3 L=0.5U W=16.64U AS=4.3264P AD=4.3264P
+ PS=20.8U PD=20.8U
M$193 \$28 UP_B \$35 VSS nfet_03v3 L=0.5U W=8.32U AS=2.8912P AD=2.8912P
+ PS=13.18U PD=13.18U
M$194 IP UP \$28 VSS nfet_03v3 L=0.5U W=8.32U AS=2.1632P AD=2.1632P PS=10.4U
+ PD=10.4U
M$201 \$147 DN_B \$323 VSS nfet_03v3 L=0.5U W=8.32U AS=2.8912P AD=2.8912P
+ PS=13.18U PD=13.18U
M$202 \$141 DN \$147 VSS nfet_03v3 L=0.5U W=8.32U AS=2.1632P AD=2.1632P
+ PS=10.4U PD=10.4U
M$209 \$74 S8 VSS VSS nfet_03v3 L=0.5U W=16U AS=4.51P AD=4.51P PS=26.02U
+ PD=26.02U
M$225 \$73 S4 VSS VSS nfet_03v3 L=0.5U W=8U AS=2.43P AD=2.43P PS=13.86U
+ PD=13.86U
M$233 \$75 S2 VSS VSS nfet_03v3 L=0.5U W=4U AS=1.39P AD=1.39P PS=7.78U PD=7.78U
M$237 \$79 S1B VSS VSS nfet_03v3 L=0.5U W=2U AS=0.87P AD=0.87P PS=4.74U PD=4.74U
M$239 \$112 S1A VSS VSS nfet_03v3 L=0.5U W=2U AS=0.87P AD=0.87P PS=4.74U
+ PD=4.74U
M$241 VSS VSS VSS VSS nfet_03v3 L=0.5U W=22.56U AS=9.8136P AD=9.8136P PS=40.8U
+ PD=40.8U
M$242 \$146 \$74 VSS VSS nfet_03v3 L=0.5U W=90.24U AS=23.4624P AD=23.4624P
+ PS=106.88U PD=106.88U
M$244 \$147 \$73 VSS VSS nfet_03v3 L=0.5U W=45.12U AS=11.7312P AD=11.7312P
+ PS=53.44U PD=53.44U
M$248 \$145 \$75 VSS VSS nfet_03v3 L=0.5U W=22.56U AS=5.8656P AD=5.8656P
+ PS=26.72U PD=26.72U
M$256 \$26 \$112 VSS VSS nfet_03v3 L=0.5U W=11.28U AS=2.9328P AD=2.9328P
+ PS=13.36U PD=13.36U
M$258 \$142 \$112 VSS VSS nfet_03v3 L=0.5U W=11.28U AS=2.9328P AD=2.9328P
+ PS=13.36U PD=13.36U
M$310 \$28 \$73 VSS VSS nfet_03v3 L=0.5U W=45.12U AS=11.7312P AD=11.7312P
+ PS=53.44U PD=53.44U
M$312 \$29 \$74 VSS VSS nfet_03v3 L=0.5U W=90.24U AS=23.4624P AD=23.4624P
+ PS=106.88U PD=106.88U
M$314 \$31 \$75 VSS VSS nfet_03v3 L=0.5U W=22.56U AS=5.8656P AD=5.8656P
+ PS=26.72U PD=26.72U
M$322 \$27 \$79 VSS VSS nfet_03v3 L=0.5U W=11.28U AS=2.9328P AD=2.9328P
+ PS=13.36U PD=13.36U
M$328 \$30 \$79 VSS VSS nfet_03v3 L=0.5U W=11.28U AS=2.9328P AD=2.9328P
+ PS=13.36U PD=13.36U
.ENDS charge_pump_top
