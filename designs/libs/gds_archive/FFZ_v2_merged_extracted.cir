* Extracted by KLayout with GF180MCU LVS runset on : 03/09/2026 10:48

.SUBCKT FFZ_v2_merged SUB
M$1 \$48 \$1 \$11 SUB nfet_03v3 L=0.5U W=16.64U AS=5.0544P AD=5.0544P PS=23.58U
+ PD=23.58U
M$9 \$49 \$1 \$10 SUB nfet_03v3 L=0.5U W=8.32U AS=2.8912P AD=2.8912P PS=13.18U
+ PD=13.18U
M$13 \$41 \$1 \$25 SUB nfet_03v3 L=0.5U W=4.16U AS=1.8096P AD=1.8096P PS=7.98U
+ PD=7.98U
M$15 \$51 \$1 \$77 SUB nfet_03v3 L=0.5U W=2.08U AS=1.2688P AD=1.2688P PS=5.38U
+ PD=5.38U
M$16 \$50 \$1 \$23 SUB nfet_03v3 L=0.5U W=2.08U AS=1.2688P AD=1.2688P PS=5.38U
+ PD=5.38U
M$17 SUB \$28 \$3 SUB nfet_03v3 L=0.5U W=8U AS=3.48P AD=3.48P PS=18.96U
+ PD=18.96U
M$21 SUB \$151 \$5 SUB nfet_03v3 L=0.5U W=2U AS=0.87P AD=0.87P PS=4.74U PD=4.74U
M$23 SUB \$118 \$6 SUB nfet_03v3 L=0.5U W=4U AS=1.74P AD=1.74P PS=9.48U PD=9.48U
M$25 SUB SUB SUB SUB nfet_03v3 L=0.5U W=22.56U AS=9.8136P AD=9.8136P PS=40.8U
+ PD=40.8U
M$26 \$49 \$6 SUB SUB nfet_03v3 L=0.5U W=45.12U AS=11.7312P AD=11.7312P
+ PS=53.44U PD=53.44U
M$28 \$48 \$3 SUB SUB nfet_03v3 L=0.5U W=90.24U AS=23.4624P AD=23.4624P
+ PS=106.88U PD=106.88U
M$30 \$41 \$5 SUB SUB nfet_03v3 L=0.5U W=22.56U AS=5.8656P AD=5.8656P PS=26.72U
+ PD=26.72U
M$50 \$51 \$113 SUB SUB nfet_03v3 L=0.5U W=11.28U AS=2.9328P AD=2.9328P
+ PS=13.36U PD=13.36U
M$52 \$50 \$112 SUB SUB nfet_03v3 L=0.5U W=11.28U AS=2.9328P AD=2.9328P
+ PS=13.36U PD=13.36U
M$103 SUB \$164 \$113 SUB nfet_03v3 L=0.5U W=1U AS=0.61P AD=0.26P PS=3.22U
+ PD=1.52U
M$104 \$112 \$165 SUB SUB nfet_03v3 L=0.5U W=1U AS=0.26P AD=0.61P PS=1.52U
+ PD=3.22U
M$105 \$1 \$1 \$1 \$1 pfet_03v3 L=1.5U W=8.8U AS=4.004P AD=4.004P PS=20.48U
+ PD=20.48U
M$106 \$10 \$10 \$1 \$1 pfet_03v3 L=1.5U W=8.8U AS=2.288P AD=2.288P PS=12.96U
+ PD=12.96U
M$108 \$11 \$11 \$1 \$1 pfet_03v3 L=1.5U W=17.6U AS=4.576P AD=4.576P PS=25.92U
+ PD=25.92U
M$118 \$25 \$25 \$1 \$1 pfet_03v3 L=1.5U W=4.4U AS=1.144P AD=1.144P PS=6.48U
+ PD=6.48U
M$120 \$23 \$23 \$1 \$1 pfet_03v3 L=1.5U W=2.2U AS=0.572P AD=0.572P PS=3.24U
+ PD=3.24U
M$138 \$77 \$77 \$1 \$1 pfet_03v3 L=1.5U W=2.2U AS=0.572P AD=0.572P PS=3.24U
+ PD=3.24U
.ENDS FFZ_v2_merged
