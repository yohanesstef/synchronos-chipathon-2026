* Extracted by KLayout with GF180MCU LVS runset on : 01/09/2026 11:18

.SUBCKT programmable_charge_pump_top UP UP_B IP VDD IP$1 S1B S2 S4 S8 DN_B DN
+ S1A|VSS
M$1 VDD VDD VDD VDD pfet_03v3 L=1.5U W=17.6U AS=8.008P AD=8.008P PS=40.96U
+ PD=40.96U
M$2 \$35 \$35 VDD VDD pfet_03v3 L=1.5U W=8.8U AS=2.288P AD=2.288P PS=12.96U
+ PD=12.96U
M$4 \$40 \$40 VDD VDD pfet_03v3 L=1.5U W=17.6U AS=4.576P AD=4.576P PS=25.92U
+ PD=25.92U
M$10 IP IP$1 VDD VDD pfet_03v3 L=1.5U W=17.6U AS=4.576P AD=4.576P PS=25.92U
+ PD=25.92U
M$12 IP \$140 VDD VDD pfet_03v3 L=1.5U W=8.8U AS=2.288P AD=2.288P PS=12.96U
+ PD=12.96U
M$22 \$25 \$25 VDD VDD pfet_03v3 L=1.5U W=2.2U AS=0.572P AD=0.572P PS=3.24U
+ PD=3.24U
M$32 IP \$139 VDD VDD pfet_03v3 L=1.5U W=2.2U AS=0.572P AD=0.572P PS=3.24U
+ PD=3.24U
M$44 \$32 \$32 VDD VDD pfet_03v3 L=1.5U W=4.4U AS=1.144P AD=1.144P PS=6.48U
+ PD=6.48U
M$46 IP \$238 VDD VDD pfet_03v3 L=1.5U W=4.4U AS=1.144P AD=1.144P PS=6.48U
+ PD=6.48U
M$62 \$64 \$64 VDD VDD pfet_03v3 L=1.5U W=2.2U AS=0.572P AD=0.572P PS=3.24U
+ PD=3.24U
M$64 IP \$272 VDD VDD pfet_03v3 L=1.5U W=2.2U AS=0.572P AD=0.572P PS=3.24U
+ PD=3.24U
M$74 \$326 \$326 VDD VDD pfet_03v3 L=1.5U W=17.6U AS=4.576P AD=4.576P PS=25.92U
+ PD=25.92U
M$78 \$327 \$327 VDD VDD pfet_03v3 L=1.5U W=4.4U AS=1.144P AD=1.144P PS=6.48U
+ PD=6.48U
M$80 \$324 \$324 VDD VDD pfet_03v3 L=1.5U W=2.2U AS=0.572P AD=0.572P PS=3.24U
+ PD=3.24U
M$82 \$272 \$272 VDD VDD pfet_03v3 L=1.5U W=2.2U AS=0.572P AD=0.572P PS=3.24U
+ PD=3.24U
M$84 \$238 \$238 VDD VDD pfet_03v3 L=1.5U W=4.4U AS=1.144P AD=1.144P PS=6.48U
+ PD=6.48U
M$86 IP$1 IP$1 VDD VDD pfet_03v3 L=1.5U W=17.6U AS=4.576P AD=4.576P PS=25.92U
+ PD=25.92U
M$92 \$325 \$325 VDD VDD pfet_03v3 L=1.5U W=8.8U AS=2.288P AD=2.288P PS=12.96U
+ PD=12.96U
M$102 \$140 \$140 VDD VDD pfet_03v3 L=1.5U W=8.8U AS=2.288P AD=2.288P PS=12.96U
+ PD=12.96U
M$112 \$386 \$386 VDD VDD pfet_03v3 L=1.5U W=2.2U AS=0.572P AD=0.572P PS=3.24U
+ PD=3.24U
M$122 \$139 \$139 VDD VDD pfet_03v3 L=1.5U W=2.2U AS=0.572P AD=0.572P PS=3.24U
+ PD=3.24U
M$145 \$30 UP_B \$32 S1A|VSS nfet_03v3 L=0.5U W=4.16U AS=1.8096P AD=1.8096P
+ PS=7.98U PD=7.98U
M$146 IP UP \$30 S1A|VSS nfet_03v3 L=0.5U W=4.16U AS=1.0816P AD=1.0816P PS=5.2U
+ PD=5.2U
M$149 \$143 DN_B \$327 S1A|VSS nfet_03v3 L=0.5U W=4.16U AS=1.8096P AD=1.8096P
+ PS=7.98U PD=7.98U
M$150 \$238 DN \$143 S1A|VSS nfet_03v3 L=0.5U W=4.16U AS=1.0816P AD=1.0816P
+ PS=5.2U PD=5.2U
M$153 \$26 UP_B \$25 S1A|VSS nfet_03v3 L=0.5U W=2.08U AS=1.2688P AD=0.5408P
+ PS=5.38U PD=2.6U
M$154 IP UP \$26 S1A|VSS nfet_03v3 L=0.5U W=2.08U AS=0.5408P AD=1.2688P PS=2.6U
+ PD=5.38U
M$155 \$31 UP_B \$64 S1A|VSS nfet_03v3 L=0.5U W=2.08U AS=1.2688P AD=0.5408P
+ PS=5.38U PD=2.6U
M$156 IP UP \$31 S1A|VSS nfet_03v3 L=0.5U W=2.08U AS=0.5408P AD=1.2688P PS=2.6U
+ PD=5.38U
M$157 \$27 DN_B \$324 S1A|VSS nfet_03v3 L=0.5U W=2.08U AS=1.2688P AD=0.5408P
+ PS=5.38U PD=2.6U
M$158 \$272 DN \$27 S1A|VSS nfet_03v3 L=0.5U W=2.08U AS=0.5408P AD=1.2688P
+ PS=2.6U PD=5.38U
M$159 \$145 DN_B \$386 S1A|VSS nfet_03v3 L=0.5U W=2.08U AS=1.2688P AD=0.5408P
+ PS=5.38U PD=2.6U
M$160 \$139 DN \$145 S1A|VSS nfet_03v3 L=0.5U W=2.08U AS=0.5408P AD=1.2688P
+ PS=2.6U PD=5.38U
M$161 \$29 UP_B \$40 S1A|VSS nfet_03v3 L=0.5U W=16.64U AS=5.0544P AD=5.0544P
+ PS=23.58U PD=23.58U
M$162 IP UP \$29 S1A|VSS nfet_03v3 L=0.5U W=16.64U AS=4.3264P AD=4.3264P
+ PS=20.8U PD=20.8U
M$177 \$147 DN_B \$326 S1A|VSS nfet_03v3 L=0.5U W=16.64U AS=5.0544P AD=5.0544P
+ PS=23.58U PD=23.58U
M$178 IP$1 DN \$147 S1A|VSS nfet_03v3 L=0.5U W=16.64U AS=4.3264P AD=4.3264P
+ PS=20.8U PD=20.8U
M$193 \$28 UP_B \$35 S1A|VSS nfet_03v3 L=0.5U W=8.32U AS=2.8912P AD=2.8912P
+ PS=13.18U PD=13.18U
M$194 IP UP \$28 S1A|VSS nfet_03v3 L=0.5U W=8.32U AS=2.1632P AD=2.1632P
+ PS=10.4U PD=10.4U
M$201 \$146 DN_B \$325 S1A|VSS nfet_03v3 L=0.5U W=8.32U AS=2.8912P AD=2.8912P
+ PS=13.18U PD=13.18U
M$202 \$140 DN \$146 S1A|VSS nfet_03v3 L=0.5U W=8.32U AS=2.1632P AD=2.1632P
+ PS=10.4U PD=10.4U
M$209 \$112 S4 \$73 VDD pfet_03v3 L=0.5U W=3U AS=1.95P AD=1.95P PS=7.3U PD=7.3U
M$210 \$112 S8 \$74 VDD pfet_03v3 L=0.5U W=3U AS=1.95P AD=1.95P PS=7.3U PD=7.3U
M$211 \$112 S2 \$75 VDD pfet_03v3 L=0.5U W=3U AS=1.95P AD=1.95P PS=7.3U PD=7.3U
M$212 \$112 S1B \$79 VDD pfet_03v3 L=0.5U W=3U AS=1.95P AD=1.95P PS=7.3U PD=7.3U
M$213 \$74 S8 S1A|VSS S1A|VSS nfet_03v3 L=0.5U W=16U AS=4.51P AD=4.51P
+ PS=26.02U PD=26.02U
M$229 \$73 S4 S1A|VSS S1A|VSS nfet_03v3 L=0.5U W=8U AS=2.43P AD=2.43P PS=13.86U
+ PD=13.86U
M$237 \$75 S2 S1A|VSS S1A|VSS nfet_03v3 L=0.5U W=4U AS=1.39P AD=1.39P PS=7.78U
+ PD=7.78U
M$241 \$79 S1B S1A|VSS S1A|VSS nfet_03v3 L=0.5U W=2U AS=0.87P AD=0.87P PS=4.74U
+ PD=4.74U
M$243 \$112 S1A|VSS S1A|VSS S1A|VSS nfet_03v3 L=0.5U W=2U AS=0.87P AD=0.87P
+ PS=4.74U PD=4.74U
M$245 \$112 \$544 \$73 S1A|VSS nfet_03v3 L=0.5U W=1U AS=0.61P AD=0.61P PS=3.22U
+ PD=3.22U
M$246 \$112 \$543 \$74 S1A|VSS nfet_03v3 L=0.5U W=1U AS=0.61P AD=0.61P PS=3.22U
+ PD=3.22U
M$247 \$112 \$545 \$75 S1A|VSS nfet_03v3 L=0.5U W=1U AS=0.61P AD=0.61P PS=3.22U
+ PD=3.22U
M$248 \$112 \$546 \$79 S1A|VSS nfet_03v3 L=0.5U W=1U AS=0.61P AD=0.61P PS=3.22U
+ PD=3.22U
M$249 S1A|VSS S1A|VSS S1A|VSS S1A|VSS nfet_03v3 L=0.5U W=22.56U AS=9.8136P
+ AD=9.8136P PS=40.8U PD=40.8U
M$250 \$147 \$74 S1A|VSS S1A|VSS nfet_03v3 L=0.5U W=90.24U AS=23.4624P
+ AD=23.4624P PS=106.88U PD=106.88U
M$252 \$146 \$73 S1A|VSS S1A|VSS nfet_03v3 L=0.5U W=45.12U AS=11.7312P
+ AD=11.7312P PS=53.44U PD=53.44U
M$256 \$143 \$75 S1A|VSS S1A|VSS nfet_03v3 L=0.5U W=22.56U AS=5.8656P
+ AD=5.8656P PS=26.72U PD=26.72U
M$264 \$26 \$112 S1A|VSS S1A|VSS nfet_03v3 L=0.5U W=11.28U AS=2.9328P
+ AD=2.9328P PS=13.36U PD=13.36U
M$266 \$145 \$112 S1A|VSS S1A|VSS nfet_03v3 L=0.5U W=11.28U AS=2.9328P
+ AD=2.9328P PS=13.36U PD=13.36U
M$318 \$28 \$73 S1A|VSS S1A|VSS nfet_03v3 L=0.5U W=45.12U AS=11.7312P
+ AD=11.7312P PS=53.44U PD=53.44U
M$320 \$29 \$74 S1A|VSS S1A|VSS nfet_03v3 L=0.5U W=90.24U AS=23.4624P
+ AD=23.4624P PS=106.88U PD=106.88U
M$322 \$30 \$75 S1A|VSS S1A|VSS nfet_03v3 L=0.5U W=22.56U AS=5.8656P AD=5.8656P
+ PS=26.72U PD=26.72U
M$330 \$27 \$79 S1A|VSS S1A|VSS nfet_03v3 L=0.5U W=11.28U AS=2.9328P AD=2.9328P
+ PS=13.36U PD=13.36U
M$336 \$31 \$79 S1A|VSS S1A|VSS nfet_03v3 L=0.5U W=11.28U AS=2.9328P AD=2.9328P
+ PS=13.36U PD=13.36U
.ENDS programmable_charge_pump_top
