* Extracted by KLayout with GF180MCU LVS runset on : 01/09/2026 11:05

.SUBCKT transmission_gate SUB
M$1 \$6 \$2 \$7 \$4 pfet_03v3 L=0.5U W=3U AS=1.95P AD=1.95P PS=7.3U PD=7.3U
M$2 \$6 \$1 \$7 SUB nfet_03v3 L=0.5U W=1U AS=0.61P AD=0.61P PS=3.22U PD=3.22U
.ENDS transmission_gate
