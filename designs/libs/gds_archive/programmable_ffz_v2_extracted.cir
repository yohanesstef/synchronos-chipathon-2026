* Extracted by KLayout with GF180MCU LVS runset on : 04/09/2026 20:44

.SUBCKT programmable_ffz_v2 S1b S2b|S3b S1|S4b VBP VBP_B VBP_C VBP_D VBP_E SUB
M$1 VBP \$12 VBP_B SUB nfet_03v3 L=0.5U W=1U AS=0.61P AD=0.26P PS=3.22U PD=1.52U
M$2 VBP_C \$9 VBP SUB nfet_03v3 L=0.5U W=2U AS=0.52P AD=0.52P PS=3.04U PD=3.04U
M$4 VBP_D \$10 VBP SUB nfet_03v3 L=0.5U W=4U AS=1.04P AD=1.04P PS=6.08U PD=6.08U
M$8 VBP_E \$20 VBP SUB nfet_03v3 L=0.5U W=8U AS=2.08P AD=2.43P PS=12.16U
+ PD=13.86U
M$16 \$73 \$20 \$78 SUB nfet_03v3 L=0.5U W=1U AS=0.61P AD=0.26P PS=3.22U
+ PD=1.52U
M$17 \$76 \$10 \$73 SUB nfet_03v3 L=0.5U W=1U AS=0.26P AD=0.61P PS=1.52U
+ PD=3.22U
M$18 \$73 \$9 \$75 SUB nfet_03v3 L=0.5U W=1U AS=0.61P AD=0.26P PS=3.22U PD=1.52U
M$19 \$72 \$12 \$73 SUB nfet_03v3 L=0.5U W=1U AS=0.26P AD=0.61P PS=1.52U
+ PD=3.22U
M$20 VBP \$2 VBP_B \$5 pfet_03v3 L=0.5U W=3U AS=1.95P AD=0.78P PS=7.3U PD=3.52U
M$21 VBP_C S1b VBP \$5 pfet_03v3 L=0.5U W=6U AS=1.56P AD=1.56P PS=7.04U PD=7.04U
M$23 VBP_D S2b|S3b VBP \$5 pfet_03v3 L=0.5U W=12U AS=3.12P AD=3.12P PS=14.08U
+ PD=14.08U
M$27 VBP_E S1|S4b VBP \$5 pfet_03v3 L=0.5U W=24U AS=6.24P AD=7.41P PS=28.16U
+ PD=31.94U
M$35 \$73 \$2 \$72 \$5 pfet_03v3 L=0.5U W=3U AS=1.95P AD=0.78P PS=7.3U PD=3.52U
M$36 \$75 S1b \$73 \$5 pfet_03v3 L=0.5U W=3U AS=0.78P AD=1.95P PS=3.52U PD=7.3U
M$37 \$73 S2b|S3b \$76 \$5 pfet_03v3 L=0.5U W=3U AS=1.95P AD=0.78P PS=7.3U
+ PD=3.52U
M$38 \$78 S1|S4b \$73 \$5 pfet_03v3 L=0.5U W=3U AS=0.78P AD=1.95P PS=3.52U
+ PD=7.3U
M$39 \$I153 \$5 VBP SUB nfet_03v3 L=0.5U W=2.08U AS=1.2688P AD=1.2688P PS=5.38U
+ PD=5.38U
M$40 \$I151 \$5 VBP_B SUB nfet_03v3 L=0.5U W=2.08U AS=1.2688P AD=1.2688P
+ PS=5.38U PD=5.38U
M$41 \$I154 \$5 VBP_E SUB nfet_03v3 L=0.5U W=16.64U AS=5.0544P AD=5.0544P
+ PS=23.58U PD=23.58U
M$49 \$I152 \$5 VBP_D SUB nfet_03v3 L=0.5U W=8.32U AS=2.8912P AD=2.8912P
+ PS=13.18U PD=13.18U
M$53 \$I150 \$5 VBP_C SUB nfet_03v3 L=0.5U W=4.16U AS=1.8096P AD=1.8096P
+ PS=7.98U PD=7.98U
M$55 SUB SUB SUB SUB nfet_03v3 L=0.5U W=22.56U AS=9.8136P AD=9.8136P PS=40.8U
+ PD=40.8U
M$56 \$I152 \$76 SUB SUB nfet_03v3 L=0.5U W=45.12U AS=11.7312P AD=11.7312P
+ PS=53.44U PD=53.44U
M$58 \$I154 \$78 SUB SUB nfet_03v3 L=0.5U W=90.24U AS=23.4624P AD=23.4624P
+ PS=106.88U PD=106.88U
M$60 \$I150 \$75 SUB SUB nfet_03v3 L=0.5U W=22.56U AS=5.8656P AD=5.8656P
+ PS=26.72U PD=26.72U
M$80 \$I153 \$73 SUB SUB nfet_03v3 L=0.5U W=11.28U AS=2.9328P AD=2.9328P
+ PS=13.36U PD=13.36U
M$82 \$I151 \$72 SUB SUB nfet_03v3 L=0.5U W=11.28U AS=2.9328P AD=2.9328P
+ PS=13.36U PD=13.36U
M$127 SUB S1|S4b \$78 SUB nfet_03v3 L=0.5U W=8U AS=3.48P AD=3.48P PS=18.96U
+ PD=18.96U
M$131 SUB S2b|S3b \$76 SUB nfet_03v3 L=0.5U W=4U AS=1.74P AD=1.74P PS=9.48U
+ PD=9.48U
M$133 SUB S1b \$75 SUB nfet_03v3 L=0.5U W=2U AS=0.87P AD=0.87P PS=4.74U PD=4.74U
M$135 \$5 \$5 \$5 \$5 pfet_03v3 L=1.5U W=8.8U AS=4.004P AD=4.004P PS=20.48U
+ PD=20.48U
M$136 VBP_D VBP_D \$5 \$5 pfet_03v3 L=1.5U W=8.8U AS=2.288P AD=2.288P PS=12.96U
+ PD=12.96U
M$138 VBP_E VBP_E \$5 \$5 pfet_03v3 L=1.5U W=17.6U AS=4.576P AD=4.576P
+ PS=25.92U PD=25.92U
M$148 VBP_C VBP_C \$5 \$5 pfet_03v3 L=1.5U W=4.4U AS=1.144P AD=1.144P PS=6.48U
+ PD=6.48U
M$150 VBP_B VBP_B \$5 \$5 pfet_03v3 L=1.5U W=2.2U AS=0.572P AD=0.572P PS=3.24U
+ PD=3.24U
M$168 VBP VBP \$5 \$5 pfet_03v3 L=1.5U W=2.2U AS=0.572P AD=0.572P PS=3.24U
+ PD=3.24U
M$181 SUB SUB \$73 SUB nfet_03v3 L=0.5U W=1U AS=0.61P AD=0.26P PS=3.22U PD=1.52U
M$182 \$72 \$2 SUB SUB nfet_03v3 L=0.5U W=1U AS=0.26P AD=0.61P PS=1.52U PD=3.22U
.ENDS programmable_ffz_v2
