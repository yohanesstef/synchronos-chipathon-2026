* Extracted by KLayout with GF180MCU LVS runset on : 20/08/2026 10:22

.SUBCKT d2s_top VBN VIP VIN VOP VO AVDD VON AVSS
M$1 VO VO VO AVDD pfet_03v3 L=0.3U W=4U AS=2.6P AD=2.6P PS=10.6U PD=10.6U
M$2 VO VON AVDD AVDD pfet_03v3 L=0.3U W=8U AS=5.2P AD=5.2P PS=21.2U PD=21.2U
M$3 AVDD VOP \$26 AVDD pfet_03v3 L=0.3U W=8U AS=5.2P AD=5.2P PS=21.2U PD=21.2U
M$6 \$26 \$26 \$26 AVDD pfet_03v3 L=0.3U W=4U AS=2.6P AD=2.6P PS=10.6U PD=10.6U
M$13 \$26 \$26 \$26 AVSS nfet_03v3 L=0.3U W=3U AS=1.83P AD=1.83P PS=8.44U
+ PD=8.44U
M$14 \$26 VO AVSS AVSS nfet_03v3 L=0.3U W=6U AS=3.66P AD=3.66P PS=16.88U
+ PD=16.88U
M$15 VO VO AVSS AVSS nfet_03v3 L=0.3U W=6U AS=3.66P AD=3.66P PS=16.88U PD=16.88U
M$19 VO VO VO AVSS nfet_03v3 L=0.3U W=3U AS=1.83P AD=1.83P PS=8.44U PD=8.44U
M$25 \$28 \$28 AVDD AVDD pfet_03v3 L=0.3U W=5.6U AS=3.64P AD=3.64P PS=16.4U
+ PD=16.4U
M$26 AVDD \$28 VOP AVDD pfet_03v3 L=0.3U W=5.6U AS=3.64P AD=3.64P PS=16.4U
+ PD=16.4U
M$28 \$28 \$28 \$28 AVDD pfet_03v3 L=0.3U W=2.8U AS=1.82P AD=1.82P PS=8.2U
+ PD=8.2U
M$29 VOP VOP VOP AVDD pfet_03v3 L=0.3U W=2.8U AS=1.82P AD=1.82P PS=8.2U PD=8.2U
M$37 \$27 \$27 AVDD AVDD pfet_03v3 L=0.3U W=5.6U AS=3.64P AD=3.64P PS=16.4U
+ PD=16.4U
M$38 AVDD \$27 VON AVDD pfet_03v3 L=0.3U W=5.6U AS=3.64P AD=3.64P PS=16.4U
+ PD=16.4U
M$40 \$27 \$27 \$27 AVDD pfet_03v3 L=0.3U W=2.8U AS=1.82P AD=1.82P PS=8.2U
+ PD=8.2U
M$41 VON VON VON AVDD pfet_03v3 L=0.3U W=2.8U AS=1.82P AD=1.82P PS=8.2U PD=8.2U
M$49 \$3 \$3 \$3 AVSS nfet_03v3 L=0.5U W=5.64U AS=2.8482P AD=2.8482P PS=10.48U
+ PD=10.48U
M$50 AVSS VBN \$3 AVSS nfet_03v3 L=0.5U W=45.12U AS=18.048P AD=18.048P
+ PS=57.92U PD=57.92U
M$51 \$4 VBN AVSS AVSS nfet_03v3 L=0.5U W=45.12U AS=18.048P AD=18.048P
+ PS=57.92U PD=57.92U
M$67 \$4 \$4 \$4 AVSS nfet_03v3 L=0.5U W=5.64U AS=2.8482P AD=2.8482P PS=10.48U
+ PD=10.48U
M$85 \$27 VIP \$3 AVSS nfet_03v3 L=0.3U W=7.6U AS=4.94P AD=4.94P PS=20.4U
+ PD=20.4U
M$86 \$3 VIN VON AVSS nfet_03v3 L=0.3U W=7.6U AS=4.94P AD=4.94P PS=20.4U
+ PD=20.4U
M$90 \$27 \$27 \$27 AVSS nfet_03v3 L=0.3U W=3.8U AS=2.47P AD=2.47P PS=10.2U
+ PD=10.2U
M$95 VON VON VON AVSS nfet_03v3 L=0.3U W=3.8U AS=2.47P AD=2.47P PS=10.2U
+ PD=10.2U
M$97 \$28 VIN \$4 AVSS nfet_03v3 L=0.3U W=7.6U AS=4.94P AD=4.94P PS=20.4U
+ PD=20.4U
M$98 \$4 VIP VOP AVSS nfet_03v3 L=0.3U W=7.6U AS=4.94P AD=4.94P PS=20.4U
+ PD=20.4U
M$102 \$28 \$28 \$28 AVSS nfet_03v3 L=0.3U W=3.8U AS=2.47P AD=2.47P PS=10.2U
+ PD=10.2U
M$107 VOP VOP VOP AVSS nfet_03v3 L=0.3U W=3.8U AS=2.47P AD=2.47P PS=10.2U
+ PD=10.2U
.ENDS d2s_top
