* Extracted by KLayout with GF180MCU LVS runset on : 29/08/2026 08:25

.SUBCKT vco_top VBN VOP4 VON4 VOP1 VON2 VOP3 VON1 VOP2 VON3 AVDD VBP AVSS
M$1 \$9 \$9 \$9 AVSS nfet_03v3 L=0.5U W=5.64U AS=2.8482P AD=2.8482P PS=10.48U
+ PD=10.48U
M$2 AVSS VBN \$9 AVSS nfet_03v3 L=0.5U W=90.24U AS=36.096P AD=36.096P
+ PS=115.84U PD=115.84U
M$3 \$5 VBN AVSS AVSS nfet_03v3 L=0.5U W=90.24U AS=36.096P AD=36.096P
+ PS=115.84U PD=115.84U
M$67 \$4 \$4 \$4 AVSS nfet_03v3 L=0.5U W=5.64U AS=2.8482P AD=2.8482P PS=10.48U
+ PD=10.48U
M$68 AVSS VBN \$4 AVSS nfet_03v3 L=0.5U W=90.24U AS=36.096P AD=36.096P
+ PS=115.84U PD=115.84U
M$69 \$7 VBN AVSS AVSS nfet_03v3 L=0.5U W=90.24U AS=36.096P AD=36.096P
+ PS=115.84U PD=115.84U
M$133 VON1 VON1 VON1 AVDD pfet_03v3 L=1.5U W=4.4U AS=2.354P AD=2.354P PS=10.88U
+ PD=10.88U
M$134 AVDD VON1 VON1 AVDD pfet_03v3 L=1.5U W=8.8U AS=3.696P AD=3.696P PS=15.52U
+ PD=15.52U
M$135 VOP1 VOP1 AVDD AVDD pfet_03v3 L=1.5U W=8.8U AS=3.696P AD=3.696P PS=15.52U
+ PD=15.52U
M$144 AVDD VBP VON1 AVDD pfet_03v3 L=1.5U W=8.8U AS=3.696P AD=3.696P PS=15.52U
+ PD=15.52U
M$145 VOP1 VBP AVDD AVDD pfet_03v3 L=1.5U W=8.8U AS=3.696P AD=3.696P PS=15.52U
+ PD=15.52U
M$153 VOP1 VOP1 VOP1 AVDD pfet_03v3 L=1.5U W=4.4U AS=2.354P AD=2.354P PS=10.88U
+ PD=10.88U
M$173 VOP4 VOP4 VOP4 AVDD pfet_03v3 L=1.5U W=4.4U AS=2.354P AD=2.354P PS=10.88U
+ PD=10.88U
M$174 AVDD VOP4 VOP4 AVDD pfet_03v3 L=1.5U W=8.8U AS=3.696P AD=3.696P PS=15.52U
+ PD=15.52U
M$175 VON4 VON4 AVDD AVDD pfet_03v3 L=1.5U W=8.8U AS=3.696P AD=3.696P PS=15.52U
+ PD=15.52U
M$184 AVDD VBP VOP4 AVDD pfet_03v3 L=1.5U W=8.8U AS=3.696P AD=3.696P PS=15.52U
+ PD=15.52U
M$185 VON4 VBP AVDD AVDD pfet_03v3 L=1.5U W=8.8U AS=3.696P AD=3.696P PS=15.52U
+ PD=15.52U
M$193 VON4 VON4 VON4 AVDD pfet_03v3 L=1.5U W=4.4U AS=2.354P AD=2.354P PS=10.88U
+ PD=10.88U
M$213 VOP2 VOP2 VOP2 AVDD pfet_03v3 L=1.5U W=4.4U AS=2.354P AD=2.354P PS=10.88U
+ PD=10.88U
M$214 AVDD VOP2 VOP2 AVDD pfet_03v3 L=1.5U W=8.8U AS=3.696P AD=3.696P PS=15.52U
+ PD=15.52U
M$215 VON2 VON2 AVDD AVDD pfet_03v3 L=1.5U W=8.8U AS=3.696P AD=3.696P PS=15.52U
+ PD=15.52U
M$224 AVDD VBP VOP2 AVDD pfet_03v3 L=1.5U W=8.8U AS=3.696P AD=3.696P PS=15.52U
+ PD=15.52U
M$225 VON2 VBP AVDD AVDD pfet_03v3 L=1.5U W=8.8U AS=3.696P AD=3.696P PS=15.52U
+ PD=15.52U
M$233 VON2 VON2 VON2 AVDD pfet_03v3 L=1.5U W=4.4U AS=2.354P AD=2.354P PS=10.88U
+ PD=10.88U
M$253 VON3 VON3 VON3 AVDD pfet_03v3 L=1.5U W=4.4U AS=2.354P AD=2.354P PS=10.88U
+ PD=10.88U
M$254 AVDD VON3 VON3 AVDD pfet_03v3 L=1.5U W=8.8U AS=3.696P AD=3.696P PS=15.52U
+ PD=15.52U
M$255 VOP3 VOP3 AVDD AVDD pfet_03v3 L=1.5U W=8.8U AS=3.696P AD=3.696P PS=15.52U
+ PD=15.52U
M$264 AVDD VBP VON3 AVDD pfet_03v3 L=1.5U W=8.8U AS=3.696P AD=3.696P PS=15.52U
+ PD=15.52U
M$265 VOP3 VBP AVDD AVDD pfet_03v3 L=1.5U W=8.8U AS=3.696P AD=3.696P PS=15.52U
+ PD=15.52U
M$273 VOP3 VOP3 VOP3 AVDD pfet_03v3 L=1.5U W=4.4U AS=2.354P AD=2.354P PS=10.88U
+ PD=10.88U
M$293 VON1 VON1 VON1 AVSS nfet_03v3 L=0.5U W=4.16U AS=2.1008P AD=2.1008P
+ PS=8.26U PD=8.26U
M$294 \$7 VON4 VON1 AVSS nfet_03v3 L=0.5U W=16.64U AS=6.656P AD=6.656P
+ PS=23.04U PD=23.04U
M$295 VOP1 VOP4 \$7 AVSS nfet_03v3 L=0.5U W=16.64U AS=6.656P AD=6.656P
+ PS=23.04U PD=23.04U
M$303 VOP1 VOP1 VOP1 AVSS nfet_03v3 L=0.5U W=4.16U AS=2.1008P AD=2.1008P
+ PS=8.26U PD=8.26U
M$313 VOP4 VOP4 VOP4 AVSS nfet_03v3 L=0.5U W=4.16U AS=2.1008P AD=2.1008P
+ PS=8.26U PD=8.26U
M$314 \$9 VOP3 VOP4 AVSS nfet_03v3 L=0.5U W=16.64U AS=6.656P AD=6.656P
+ PS=23.04U PD=23.04U
M$315 VON4 VON3 \$9 AVSS nfet_03v3 L=0.5U W=16.64U AS=6.656P AD=6.656P
+ PS=23.04U PD=23.04U
M$323 VON4 VON4 VON4 AVSS nfet_03v3 L=0.5U W=4.16U AS=2.1008P AD=2.1008P
+ PS=8.26U PD=8.26U
M$333 VOP2 VOP2 VOP2 AVSS nfet_03v3 L=0.5U W=4.16U AS=2.1008P AD=2.1008P
+ PS=8.26U PD=8.26U
M$334 \$4 VOP1 VOP2 AVSS nfet_03v3 L=0.5U W=16.64U AS=6.656P AD=6.656P
+ PS=23.04U PD=23.04U
M$335 VON2 VON1 \$4 AVSS nfet_03v3 L=0.5U W=16.64U AS=6.656P AD=6.656P
+ PS=23.04U PD=23.04U
M$343 VON2 VON2 VON2 AVSS nfet_03v3 L=0.5U W=4.16U AS=2.1008P AD=2.1008P
+ PS=8.26U PD=8.26U
M$353 VON3 VON3 VON3 AVSS nfet_03v3 L=0.5U W=4.16U AS=2.1008P AD=2.1008P
+ PS=8.26U PD=8.26U
M$354 \$5 VON2 VON3 AVSS nfet_03v3 L=0.5U W=16.64U AS=6.656P AD=6.656P
+ PS=23.04U PD=23.04U
M$355 VOP3 VOP2 \$5 AVSS nfet_03v3 L=0.5U W=16.64U AS=6.656P AD=6.656P
+ PS=23.04U PD=23.04U
M$363 VOP3 VOP3 VOP3 AVSS nfet_03v3 L=0.5U W=4.16U AS=2.1008P AD=2.1008P
+ PS=8.26U PD=8.26U
.ENDS vco_top
