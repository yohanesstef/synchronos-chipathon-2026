* Extracted by KLayout with GF180MCU LVS runset on : 01/09/2026 13:54

.SUBCKT vco_top VBN VON4 VOP4 VOP1 VON2 VOP3 VON3 VON1 VOP2 AVDD VBP AVSS
M$1 \$9 \$9 \$9 AVSS nfet_03v3 L=0.5U W=5.64U AS=2.8482P AD=2.8482P PS=10.48U
+ PD=10.48U
M$2 AVSS VBN \$9 AVSS nfet_03v3 L=0.5U W=90.24U AS=36.096P AD=36.096P
+ PS=115.84U PD=115.84U
M$3 \$5 VBN AVSS AVSS nfet_03v3 L=0.5U W=90.24U AS=36.096P AD=36.096P
+ PS=115.84U PD=115.84U
M$67 \$4 \$4 \$4 AVSS nfet_03v3 L=0.5U W=5.64U AS=2.8482P AD=2.8482P PS=10.48U
+ PD=10.48U
M$68 AVSS VBN \$4 AVSS nfet_03v3 L=0.5U W=90.24U AS=36.096P AD=36.096P
+ PS=115.84U PD=115.84U
M$69 \$6 VBN AVSS AVSS nfet_03v3 L=0.5U W=90.24U AS=36.096P AD=36.096P
+ PS=115.84U PD=115.84U
M$133 \$6 VOP4 VON1 AVSS nfet_03v3 L=0.5U W=16.64U AS=7.0928P AD=7.0928P
+ PS=25.54U PD=25.54U
M$134 VOP1 VON4 \$6 AVSS nfet_03v3 L=0.5U W=16.64U AS=7.0928P AD=7.0928P
+ PS=25.54U PD=25.54U
M$149 \$9 VOP3 VOP4 AVSS nfet_03v3 L=0.5U W=16.64U AS=7.0928P AD=7.0928P
+ PS=25.54U PD=25.54U
M$150 VON4 VON3 \$9 AVSS nfet_03v3 L=0.5U W=16.64U AS=7.0928P AD=7.0928P
+ PS=25.54U PD=25.54U
M$165 \$4 VOP1 VOP2 AVSS nfet_03v3 L=0.5U W=16.64U AS=7.0928P AD=7.0928P
+ PS=25.54U PD=25.54U
M$166 VON2 VON1 \$4 AVSS nfet_03v3 L=0.5U W=16.64U AS=7.0928P AD=7.0928P
+ PS=25.54U PD=25.54U
M$181 \$5 VON2 VON3 AVSS nfet_03v3 L=0.5U W=16.64U AS=7.0928P AD=7.0928P
+ PS=25.54U PD=25.54U
M$182 VOP3 VOP2 \$5 AVSS nfet_03v3 L=0.5U W=16.64U AS=7.0928P AD=7.0928P
+ PS=25.54U PD=25.54U
M$197 AVDD VON1 VON1 AVDD pfet_03v3 L=1.5U W=8.8U AS=3.949P AD=3.949P PS=17.08U
+ PD=17.08U
M$198 VOP1 VOP1 AVDD AVDD pfet_03v3 L=1.5U W=8.8U AS=3.949P AD=3.949P PS=17.08U
+ PD=17.08U
M$205 AVDD VBP VON1 AVDD pfet_03v3 L=1.5U W=8.8U AS=3.949P AD=3.949P PS=17.08U
+ PD=17.08U
M$206 VOP1 VBP AVDD AVDD pfet_03v3 L=1.5U W=8.8U AS=3.949P AD=3.949P PS=17.08U
+ PD=17.08U
M$229 AVDD VOP4 VOP4 AVDD pfet_03v3 L=1.5U W=8.8U AS=3.949P AD=3.949P PS=17.08U
+ PD=17.08U
M$230 VON4 VON4 AVDD AVDD pfet_03v3 L=1.5U W=8.8U AS=3.949P AD=3.949P PS=17.08U
+ PD=17.08U
M$237 AVDD VBP VOP4 AVDD pfet_03v3 L=1.5U W=8.8U AS=3.949P AD=3.949P PS=17.08U
+ PD=17.08U
M$238 VON4 VBP AVDD AVDD pfet_03v3 L=1.5U W=8.8U AS=3.949P AD=3.949P PS=17.08U
+ PD=17.08U
M$261 AVDD VOP2 VOP2 AVDD pfet_03v3 L=1.5U W=8.8U AS=3.949P AD=3.949P PS=17.08U
+ PD=17.08U
M$262 VON2 VON2 AVDD AVDD pfet_03v3 L=1.5U W=8.8U AS=3.949P AD=3.949P PS=17.08U
+ PD=17.08U
M$269 AVDD VBP VOP2 AVDD pfet_03v3 L=1.5U W=8.8U AS=3.949P AD=3.949P PS=17.08U
+ PD=17.08U
M$270 VON2 VBP AVDD AVDD pfet_03v3 L=1.5U W=8.8U AS=3.949P AD=3.949P PS=17.08U
+ PD=17.08U
M$293 AVDD VON3 VON3 AVDD pfet_03v3 L=1.5U W=8.8U AS=3.949P AD=3.949P PS=17.08U
+ PD=17.08U
M$294 VOP3 VOP3 AVDD AVDD pfet_03v3 L=1.5U W=8.8U AS=3.949P AD=3.949P PS=17.08U
+ PD=17.08U
M$301 AVDD VBP VON3 AVDD pfet_03v3 L=1.5U W=8.8U AS=3.949P AD=3.949P PS=17.08U
+ PD=17.08U
M$302 VOP3 VBP AVDD AVDD pfet_03v3 L=1.5U W=8.8U AS=3.949P AD=3.949P PS=17.08U
+ PD=17.08U
.ENDS vco_top
